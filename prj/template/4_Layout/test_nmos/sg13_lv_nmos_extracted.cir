* Extracted by KLayout with SG13G2 LVS runset on : 09/05/2025 10:32

.SUBCKT sg13_lv_nmos
M$1 \$8 \$18 \$19 \$1 sg13_lv_nmos L=0.25u W=0.6u AS=0.312p AD=0.312p PS=4.02u
+ PD=4.02u
M$4 \$20 \$22 \$21 \$1 sg13_lv_nmos L=0.15u W=0.6u AS=0.312p AD=0.312p PS=4.16u
+ PD=4.16u
M$6 \$3 \$7 \$4 \$1 sg13_lv_nmos L=0.3u W=0.3u AS=0.201p AD=0.201p PS=2.82u
+ PD=2.82u
M$11 \$9 \$15 \$10 \$1 sg13_lv_nmos L=0.13u W=0.15u AS=0.1005p AD=0.1005p
+ PS=1.34u PD=1.34u
M$12 \$2 \$5 \$6 \$1 sg13_lv_nmos L=0.15u W=0.3u AS=0.156p AD=0.156p PS=2.08u
+ PD=2.08u
M$14 \$11 \$17 \$12 \$1 sg13_lv_nmos L=0.13u W=0.2u AS=0.104p AD=0.104p
+ PS=1.34u PD=1.34u
M$15 \$13 \$16 \$14 \$1 sg13_lv_nmos L=0.15u W=0.2u AS=0.104p AD=0.104p
+ PS=1.34u PD=1.34u
.ENDS sg13_lv_nmos

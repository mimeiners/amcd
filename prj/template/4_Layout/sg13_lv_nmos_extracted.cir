* Extracted by KLayout with SG13G2 LVS runset on : 09/05/2025 10:51

.SUBCKT sg13_lv_nmos
M$1 \$5 \$11 \$2 \$1 sg13_lv_nmos L=0.3u W=0.3u AS=0.201p AD=0.201p PS=2.82u
+ PD=2.82u
M$4 \$3 \$7 \$4 \$1 sg13_lv_nmos L=0.15u W=0.3u AS=0.156p AD=0.156p PS=2.08u
+ PD=2.08u
M$6 \$6 \$18 \$8 \$1 sg13_lv_nmos L=0.13u W=0.15u AS=0.1005p AD=0.1005p
+ PS=1.34u PD=1.34u
M$7 \$9 \$19 \$10 \$1 sg13_lv_nmos L=0.13u W=0.2u AS=0.104p AD=0.104p PS=1.34u
+ PD=1.34u
M$8 \$15 \$20 \$16 \$1 sg13_lv_nmos L=0.15u W=0.2u AS=0.104p AD=0.104p PS=1.34u
+ PD=1.34u
M$9 \$12 \$13 \$14 \$1 sg13_lv_nmos L=0.25u W=0.6u AS=0.312p AD=0.312p PS=4.02u
+ PD=4.02u
M$10 \$21 \$22 \$17 \$1 sg13_lv_nmos L=0.15u W=0.6u AS=0.312p AD=0.312p
+ PS=4.16u PD=4.16u
.ENDS sg13_lv_nmos
